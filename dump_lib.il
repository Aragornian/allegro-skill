;导出PCB上的一个或多个Package
axlCmdRegister("pk" 'DumpPackage ?cmdType "interactive" ?doneCmd 'axlDPDone ?cancelCmd 'axlDPCancel)

;导出PCB上的一个或多个Pad
axlCmdRegister("pd" 'DumpPadstack ?cmdType "interactive" ?doneCmd 'axlPadDone ?cancelCmd 'axlDPCancel)

procedure(DumpPackage()
	let((mypopup)
	mypopup = axlUIPopupDefine(nil (list (list "Done" 'axlDPDone) (list "Cancel" 'axlDPCancel)))
	axlUIPopupSet(mypopup)
	axlClearSelSet()
	axlSetFindFilter(?enabled '("noall" "symbols") ?onButtons "symbols")
	while(axlSelect(?prompt "please select symbols!") t)
	)
)

procedure(axlDPCancel()
	axlClearSelSet()
	axlCancelEnterFun()
)
procedure(axlDPDone()
	let(((lid nil) (outdir "./Package"))
	lid = axlGetSelSet()
	if(lid != nil && !isDir("./Package")
		then createDir("./Package")
	)
	foreach(pid lid
		if(axlWritePackageFile(pid->definition outdir)
			then printf(strcat("\nExport package: " pid->name " Successful!"))
		else
			printf(strcat("fail to export package: " pid->name "\n"))
			printf(strcat("incorrect dbid or directory " simplifyFilename(outdir)))
		)
	)
	axlClearSelSet()
	axlFinishEnterFun()
	)
)

procedure(DumpPadstack()
	let((mypopup)
	mypopup = axlUIPopupDefine(nil (list (list "Done" 'axlPadDone) (list "Cancel" 'axlDPCancel)))
	axlUIPopupSet(mypopup)
	axlClearSelSet()
	axlSetFindFilter(?enabled '("noall" "pins" "vias") ?onButtons '("pins" "vias"))
	while(axlSelect(?prompt "please select padstacks!") t)
	)
)

procedure(axlPadDone()
	let(((lid nil) (outdir "./Padstack") currentworkingdir)
	lid = axlGetSelSet()
	if(lid != nil && !isDir("./Padstack")
		then createDir("./Padstack")
	)
	currentworkingdir = getWorkingDir()
	foreach(pid lid
		changeWorkingDir(outdir)
		if(axlPadstackToDisk(pid->name)
			then printf(strcat("\nExport Padstack: " pid->name " Successful!"))
		else
			printf(strcat("fail to export padstacks: " pid->name "\n"))
			printf(strcat("incorrect dbid or directory " simplifyFilename(outdir)))
		)
	)
	changeWorkingDir(currentworkingdir)
	axlClearSelSet()
	axlFinishEnterFun()
	)
)
